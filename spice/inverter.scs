// Example netlist of inverter using spectre vcvs
// This file is parsed to find only the top-level subcircuit
// Top level subcircuit name is defined with the line below:
// Design cell name: inverter

SUBCKT inverter A Z
    e1 ( Z 0 A 0 ) vcvs min=0 max=1 pwl=[0 1 0.5 0.5 1 0] scale=1 stretch=1
ENDS inverter
